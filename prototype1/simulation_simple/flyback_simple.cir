* Prototype 1 - simplest useful model of the flyback converter (ngspice)
* Run:  ngspice -b flyback_simple.cir
* No vendor models and no subcircuits. Every value is a datasheet number
* or follows from one; see README.md in this directory.

.param VIN=5          ; supply voltage, V
.param FSW=100k       ; switching frequency, Hz
.param DUTY=0.49      ; duty cycle
.param RLOAD=9.63k    ; load resistance, ohm
.param VSTART=170     ; initial output voltage, V (ideal value for this point)
.param TSW={1/FSW}

* --- supply: ideal source ---------------------------------------------------
VIN   vin 0 {VIN}

* --- gate drive: ideal 0-5 V pulse behind the driver output resistance ------
VDRV  drv 0 PULSE(0 {VIN} 0 10n 10n {DUTY*TSW - 10n} {TSW})
RDRV  drv g1 3.4      ; MCP1407 output resistance at 5 V (4.0 up, 2.7 down)

* --- transformer DA2033-AL: Lp, Ls = N^2 Lp, leakage, winding resistance ----
RP    vin p1 15m
LP    p1 drain 10u
LS    0 s1 1m
RS    s1 sec 1.1
KT    LP LS 0.99277   ; leakage 0.144 uH: k = sqrt(1 - Llk/Lp)

* --- MOSFET CSD18533KCS: switch + three constant capacitors + body diode ----
RG    g1 gate 1.4     ; internal gate resistance
CGS   gate 0 2413p    ; Ciss - Crss
CGD   gate drain 130p ; Qgd / 30 V
CDS   drain 0 903p    ; Qoss / 30 V - Cgd
SQ1   drain 0 gate 0 QSW
DQ1   0 drain DBODY
.model QSW SW(vt=1.9 vh=0.1 ron=6.9m roff=100meg)
.model DBODY D(is=1n n=1 rs=2m)

* --- output diode QH05TZ600 --------------------------------------------------
D1    sec out DOUT
.model DOUT D(is=8.4p n=2 rs=0.24 cjo=41p vj=1 m=0.37 tt=1.3n bv=600 ibv=250u)

* --- output capacitor and load: ideal ---------------------------------------
COUT  out 0 2.2u ic={VSTART}
RLOAD out 0 {RLOAD}

* --- analysis ---------------------------------------------------------------
.options method=gear reltol=1e-3 abstol=1n vntol=1u
.save v(vin) v(drv) v(gate) v(drain) v(sec) v(out) i(vin) i(vdrv) i(ls) @rload[i]
.tran 5n 100m 0 20n uic

.control
set noaskquit
run
let iin  = -i(vin)
let pin  = v(vin)*iin
let pout = v(out)*@rload[i]
let pdrv = -v(drv)*i(vdrv)
let vdio = v(out) - v(sec)

* steady state: last 20 switching periods
let t1 = 100m - 200u
let t2 = 100m
meas tran vout_avg   avg v(out)   from=t1 to=t2
meas tran vout_pp    pp  v(out)   from=t1 to=t2
meas tran iout_avg   avg @rload[i] from=t1 to=t2
meas tran iin_avg    avg iin      from=t1 to=t2
meas tran iin_max    max iin      from=t1 to=t2
meas tran isec_max   max i(ls)    from=t1 to=t2
meas tran vds_max    max v(drain) from=t1 to=t2
meas tran vdio_max   max vdio     from=t1 to=t2
meas tran pin_avg    avg pin      from=t1 to=t2
meas tran pout_avg   avg pout     from=t1 to=t2
meas tran pdrv_avg   avg pdrv     from=t1 to=t2
let eta = pout_avg/pin_avg
print eta

* waveforms of the last two periods -> waveforms.txt
let cut-tstart = 100m - 20u
let cut-tstop  = 100m
cutout
let iin = -i(vin)
wrdata waveforms.txt v(gate) v(drain) v(sec) v(out) iin i(ls)
.endc
.end
